.lib /usr/local/share/pdk/sky130A/libs.tech/ngspice/sky130.lib.spice tt

.include ../DOMINO_AND.spice

VVDD VDD 0 1.8

VCLK CLK 0 PULSE(0 1.8 4n 50p 50p 4n 8n)

VA A 0 PWL(
+ 0 0
+ 16.5n 0
+ 16.55n 1.8
+ 32n 1.8
+ )

VB B 0 PWL(
+ 0 0
+ 8.5n 0
+ 8.55n 1.8
+ 16.5n 1.8
+ 16.55n 0
+ 24.5n 0
+ 24.55n 1.8
+ 32n 1.8
+ )

.control
save all

tran 5p 32n

write ../data/domino_postlayout.raw

set wr_singlescale
set wr_vecnames

wrdata ../data/domino_postlayout_waveforms.dat v(CLK) v(A) v(B) v(X) v(OUT)

meas tran tclk50 WHEN v(CLK)=0.9 RISE=4
meas tran tx50 WHEN v(X)=0.9 FALL=1 FROM=28n TO=29n
meas tran tout50 WHEN v(OUT)=0.9 RISE=1 FROM=28n TO=29n

meas tran tpd_x TRIG v(CLK) VAL=0.9 RISE=4 TARG v(X) VAL=0.9 FALL=1
meas tran tpd_out TRIG v(CLK) VAL=0.9 RISE=4 TARG v(OUT) VAL=0.9 RISE=1

meas tran x_fall TRIG v(X) VAL=1.62 FALL=1 TARG v(X) VAL=0.18 FALL=1 FROM=28n TO=29n
meas tran out_rise TRIG v(OUT) VAL=0.18 RISE=1 TARG v(OUT) VAL=1.62 RISE=1
meas tran clk_rise TRIG v(CLK) VAL=0.18 RISE=4 TARG v(CLK) VAL=1.62 RISE=4

plot v(CLK) v(A) v(B)
plot v(X) v(OUT)

.endc

.end
